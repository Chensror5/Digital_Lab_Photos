ADE simulation setup
Run mode: Single Run, Sweeps and Corners
Tests:
  Lab5:Inverter_TB:1: Lab5/Inverter_TB/config, simulator spectre
    Outputs: Tpd
  Lab5:Inverter_TB:2: Lab5/Inverter_TB/schematic, simulator spectre
    Outputs: NML; NMH
  Lab5:Inverter_TB:3: Lab5/Inverter_TB/schematic, simulator spectre
Global variables:
  V_in_delay = 0
  V_in_fall = 100p
  V_in_high = VDD
  V_in_low = 0
  V_in_per = 100n
  V_in_rise = 100p
  VDD = 1.8
  C = 1p
  X = 1, 2, 3, 4 (off)
  Beta = 2, 4, 6, 8, 10
  V_in = 1
